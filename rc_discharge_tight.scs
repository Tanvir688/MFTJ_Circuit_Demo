simulator lang=spectre
global 0

// ON-state delay convergence check for rc_discharge_5ms.scs.
// Run from the repository root.
// spectre rc_discharge_tight.scs -format psfascii -raw rc_tight_results +log rc_tight.log
ahdl_include "./mftj_equations.va"

parameters vpre=0.200 vtrip=0.100 cbl=1p area_um2_demo=1.99 ron_pre=100
parameters nq_e=8 nq_t=12 nbar=32 ntail=32

// DC precharge followed by release at the 0.5 V breakpoint at 1 ns.
Vsupply (supply 0) vsource dc=vpre
Vprectl (pre 0) vsource type=pwl dc=1 wave=[0 1 1n 0.5 2n 0]

subckt read_cell (bl supply pre)
    parameters fe_sign=1 mag_sign=1
    Spre (supply bl pre) MFTJ_Tanvir_Precharge ron=ron_pre
    Cbit (bl 0) capacitor c=cbl
    Xj (0 bl) MFTJ_Tanvir_Equations area_um2=area_um2_demo \
        initial_sign=fe_sign alignment=mag_sign \
        energy_order=nq_e transverse_order=nq_t barrier_slices=nbar tail_slices=ntail
ends read_cell

// All four cells participate in the solve as in the 5 ms demo.
Xonp   (bl_on_p   supply pre) read_cell fe_sign=1  mag_sign=1
Xonap  (bl_on_ap  supply pre) read_cell fe_sign=1  mag_sign=-1
Xoffp  (bl_off_p  supply pre) read_cell fe_sign=-1 mag_sign=1
Xoffap (bl_off_ap supply pre) read_cell fe_sign=-1 mag_sign=-1

simulatorOptions options temp=-153.15 tnom=-153.15 reltol=1e-6 \
    vabstol=1n iabstol=100a gmin=1e-15 cmin=0
saveOptions options save=selected
save pre bl_on_p bl_on_ap
tran1 tran stop=120n maxstep=200p skipdc=no errpreset=moderate method=gear2only

// Delays and the interval between the two falling bitline crossings, all in seconds.
// The 5 ms run measured 84.0519 ns (P), 85.8121 ns (AP), and a 1.7602 ns gap.
simulator lang=spice
.measure tran delay_on_p  TRIG V(pre)     VAL=0.5     FALL=1 TARG V(bl_on_p)  VAL='vtrip' FALL=1
.measure tran delay_on_ap TRIG V(pre)     VAL=0.5     FALL=1 TARG V(bl_on_ap) VAL='vtrip' FALL=1
.measure tran gap_on_ap_p TRIG V(bl_on_p) VAL='vtrip' FALL=1 TARG V(bl_on_ap) VAL='vtrip' FALL=1
simulator lang=spectre
